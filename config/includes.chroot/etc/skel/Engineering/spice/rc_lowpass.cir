RC low-pass filter, cutoff about 1.6 kHz
V1 in 0 AC 1
R1 in out 1k
C1 out 0 100n
.ac dec 20 10 1Meg
.control
run
plot vdb(out)
.endc
.end
